{ name: "mage",
  clock_primary: "clk_i",
  bus_interfaces: [
    { protocol: "reg_iface", direction: "device" }
  ],
  registers: [

    { multireg:
        { name: "CFG_PE_00",
        desc: "Configuration for MAGE-CGRA PE 00",
        count : "1",
        cname: "PE_00",
        swaccess: "rw",
        hwaccess: "hro",
        fields: [
        { bits: "31:0"
        }
        ],
        }
    },
    { multireg:
        { name: "CFG_PE_01",
        desc: "Configuration for MAGE-CGRA PE 00",
        count : "1",
        cname: "PE_01",
        swaccess: "rw",
        hwaccess: "hro",
        fields: [
        { bits: "31:0"
        }
        ],
        }
    },
    { multireg:
        { name: "CFG_PE_02",
        desc: "Configuration for MAGE-CGRA PE 00",
        count : "1",
        cname: "PE_02",
        swaccess: "rw",
        hwaccess: "hro",
        fields: [
        { bits: "31:0"
        }
        ],
        }
    },
    { multireg:
        { name: "CFG_PE_03",
        desc: "Configuration for MAGE-CGRA PE 00",
        count : "1",
        cname: "PE_03",
        swaccess: "rw",
        hwaccess: "hro",
        fields: [
        { bits: "31:0"
        }
        ],
        }
    },
    { multireg:
        { name: "CFG_PE_10",
        desc: "Configuration for MAGE-CGRA PE 00",
        count : "1",
        cname: "PE_10",
        swaccess: "rw",
        hwaccess: "hro",
        fields: [
        { bits: "31:0"
        }
        ],
        }
    },
    { multireg:
        { name: "CFG_PE_11",
        desc: "Configuration for MAGE-CGRA PE 00",
        count : "1",
        cname: "PE_11",
        swaccess: "rw",
        hwaccess: "hro",
        fields: [
        { bits: "31:0"
        }
        ],
        }
    },
    { multireg:
        { name: "CFG_PE_12",
        desc: "Configuration for MAGE-CGRA PE 00",
        count : "1",
        cname: "PE_12",
        swaccess: "rw",
        hwaccess: "hro",
        fields: [
        { bits: "31:0"
        }
        ],
        }
    },
    { multireg:
        { name: "CFG_PE_13",
        desc: "Configuration for MAGE-CGRA PE 00",
        count : "1",
        cname: "PE_13",
        swaccess: "rw",
        hwaccess: "hro",
        fields: [
        { bits: "31:0"
        }
        ],
        }
    },
    { multireg:
        { name: "CFG_PE_20",
        desc: "Configuration for MAGE-CGRA PE 00",
        count : "1",
        cname: "PE_20",
        swaccess: "rw",
        hwaccess: "hro",
        fields: [
        { bits: "31:0"
        }
        ],
        }
    },
    { multireg:
        { name: "CFG_PE_21",
        desc: "Configuration for MAGE-CGRA PE 00",
        count : "1",
        cname: "PE_21",
        swaccess: "rw",
        hwaccess: "hro",
        fields: [
        { bits: "31:0"
        }
        ],
        }
    },
    { multireg:
        { name: "CFG_PE_22",
        desc: "Configuration for MAGE-CGRA PE 00",
        count : "1",
        cname: "PE_22",
        swaccess: "rw",
        hwaccess: "hro",
        fields: [
        { bits: "31:0"
        }
        ],
        }
    },
    { multireg:
        { name: "CFG_PE_23",
        desc: "Configuration for MAGE-CGRA PE 00",
        count : "1",
        cname: "PE_23",
        swaccess: "rw",
        hwaccess: "hro",
        fields: [
        { bits: "31:0"
        }
        ],
        }
    },
    { multireg:
        { name: "CFG_PE_30",
        desc: "Configuration for MAGE-CGRA PE 00",
        count : "1",
        cname: "PE_30",
        swaccess: "rw",
        hwaccess: "hro",
        fields: [
        { bits: "31:0"
        }
        ],
        }
    },
    { multireg:
        { name: "CFG_PE_31",
        desc: "Configuration for MAGE-CGRA PE 00",
        count : "1",
        cname: "PE_31",
        swaccess: "rw",
        hwaccess: "hro",
        fields: [
        { bits: "31:0"
        }
        ],
        }
    },
    { multireg:
        { name: "CFG_PE_32",
        desc: "Configuration for MAGE-CGRA PE 00",
        count : "1",
        cname: "PE_32",
        swaccess: "rw",
        hwaccess: "hro",
        fields: [
        { bits: "31:0"
        }
        ],
        }
    },
    { multireg:
        { name: "CFG_PE_33",
        desc: "Configuration for MAGE-CGRA PE 00",
        count : "1",
        cname: "PE_33",
        swaccess: "rw",
        hwaccess: "hro",
        fields: [
        { bits: "31:0"
        }
        ],
        }
    },
    { multireg:
        { name: "PEA_CONSTANTS",
        desc: "Configuration for PEs constants",
        count : "16",
        cname: "PEA_CONSTANTS",
        swaccess: "rw",
        hwaccess: "hro",
        fields: [
        { bits: "31:0",
          name: "CONSTANT",
          desc: "Constant for PE"
        },
        ],
        }
    },
    { name: "STREAM_DMA_CFG",
      desc: "Selection signals for output of MAGE-CGRA PEA",
      swaccess: "rw",
      hwaccess: "hro",
      fields: [
      { bits: "3:0",
        name: "DMA_CH_CFG",
        desc: "Configuration for DMA channels (r or r/w)"
      },
      ],
    },
    { name: "SEPARATE_COLS",
      desc: "If set to 1, each column of Mage works in streaming separately from all the other. If 0, all columns work together. If 2, columns are grouped in 2 groups of 2 each",
      swaccess: "rw",
      hwaccess: "hro",
      fields: [
      { bits: "1:0",
        name: "SEP_COLS",
        desc: "Configuration for separate Mage columns in streaming"
      },
      ],
    },
    { name: "STREAM_IN_XBAR_SEL",
      desc: "Selection signals for input stream crossbars",
      swaccess: "rw",
      hwaccess: "hro",
      fields: [
      { bits: "1:0",
        name: "SEL_IN_XBAR_0",
        desc: "Selection signals for output stream crossbar"
      },
      { bits: "3:2",
        name: "SEL_IN_XBAR_1",
        desc: "Selection signals for output stream crossbar"
      },
      { bits: "5:4",
        name: "SEL_IN_XBAR_2",
        desc: "Selection signals for output stream crossbar"
      },
      { bits: "7:6",
        name: "SEL_IN_XBAR_3",
        desc: "Selection signals for output stream crossbar"
      },
      ],
    },
    { name: "STREAM_OUT_XBAR_SEL",
      desc: "Selection signals for output stream crossbars",
      swaccess: "rw",
      hwaccess: "hro",
      fields: [
      { bits: "1:0",
        name: "SEL_OUT_XBAR_0",
        desc: "Selection signals for output stream crossbar"
      },
      { bits: "3:2",
        name: "SEL_OUT_XBAR_1",
        desc: "Selection signals for output stream crossbar"
      },
      { bits: "5:4",
        name: "SEL_OUT_XBAR_2",
        desc: "Selection signals for output stream crossbar"
      },
      { bits: "7:6",
        name: "SEL_OUT_XBAR_3",
        desc: "Selection signals for output stream crossbar"
      },
      ],
    },
    { multireg:
      { name: "SEL_OUT_COL_PEA",
      desc: "Selection signals for output of MAGE-CGRA PEA",
      count : "1",
      cname: "SEL_OUT_COL_PEA",
      swaccess: "rw",
      hwaccess: "hro",
      fields: [
      { bits: "7:0",
        name: "SEL_COL_0",
        desc: "Selector for column 0"
      },
      { bits: "15:8",
        name: "SEL_COL_1",
        desc: "Selector for column 1"
      },
      { bits: "23:16",
        name: "SEL_COL_2",
        desc: "Selector for column 2"
      },
      { bits: "31:24",
        name: "SEL_COL_3",
        desc: "Selector for column 3"
      },
      ],
      }
    },
    { multireg:
      { name: "ACC_VALUE",
      desc: "Accumulation Value for PEs",
      count : "4",
      cname: "ACC_VALUE_PE",
      swaccess: "rw",
      hwaccess: "hro",
      fields: [
      { bits: "7:0",
        name: "PE_0",
        desc: "Selector for column 0"
      },
      { bits: "15:8",
        name: "PE_1",
        desc: "Selector for column 1"
      },
      { bits: "23:16",
        name: "PE_2",
        desc: "Selector for column 2"
      },
      { bits: "31:24",
        name: "PE_3",
        desc: "Selector for column 3"
      },
      ],
      }
    },
  ]
}